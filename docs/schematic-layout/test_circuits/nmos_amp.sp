NMOS Common-Source Amplifier
VDD 1 0 DC 5
RD 1 2 1k
M1 2 3 0 0 NMOS
Vin 3 0 DC 1
.END
